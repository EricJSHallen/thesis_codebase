; ============================================================
; Minimal OCEAN test script
; Test one pair of PWL files and export transient outputs
; ============================================================

simulator('spectre)

; ------------------------------------------------------------
; Design under test
; ------------------------------------------------------------

design("sebastian_thesis_pilot" "synapsedualinputtb" "schematic")

; ------------------------------------------------------------
; Directory setup
; ------------------------------------------------------------

baseRepoDir = "/home/s5117909/Documents/thesis/sebastian_thesis_repo"

pwlBaseDir = strcat(baseRepoDir "/processing/general_code/spike_train_output")

outputBaseDir = strcat(baseRepoDir "/processing/cadence_extraction/testoutput")

runName = "test"
runDir = strcat(outputBaseDir "/" runName)

unless(isDir(outputBaseDir)
    system(strcat("mkdir -p " outputBaseDir))
)

unless(isDir(runDir)
    system(strcat("mkdir -p " runDir))
)

; Send Spectre output data to this directory.
resultsDir(runDir)

; ------------------------------------------------------------
; Analysis
; ------------------------------------------------------------

analysis('tran ?stop "1s")

; ------------------------------------------------------------
; Define ordinary design variables
; ------------------------------------------------------------
; These values are copied from the ADE design-variable list.
; Dependent variables are assigned directly to avoid undefined
; variable problems in the generated Spectre netlist.
; ------------------------------------------------------------

desVar("ml" 180n)
desVar("mw" 180n)

desVar("m2l"   180n)
desVar("m2ltb" 180n)
desVar("m2w"   180n)
desVar("m2wtb" 180n)

desVar("m3l" 180n)
desVar("m3w" 180n)

desVar("m4l"   180n)
desVar("m4ltb" 180n)
desVar("m4w"   180n)
desVar("m4wtb" 180n)

desVar("m5l" 180n)
desVar("m5w" 180n)

desVar("pw"   100u)
desVar("T"    1m)
desVar("Vin"  0)
desVar("Vtau" 1.7)
desVar("Vthr" 0.6)
desVar("Vw"   1.0)
desVar("vmax" 1.8)

; ------------------------------------------------------------
; PWL design variables
; ------------------------------------------------------------
; The actual Spectre parameter value must include quotation marks.
; Therefore the file paths are wrapped with "\"" ... "\"".
; ------------------------------------------------------------

st1File = strcat(pwlBaseDir "/st_1/600_hz/trial_1.pwl")
st2File = strcat(pwlBaseDir "/st_2/600_hz/trial_1.pwl")

unless(isFile(st1File)
    error("Cannot find st_1 PWL file: %s\n" st1File)
)

unless(isFile(st2File)
    error("Cannot find st_2 PWL file: %s\n" st2File)
)

desVar("pwlFile_st1" strcat("\"" st1File "\""))
desVar("pwlFile_st2" strcat("\"" st2File "\""))

printf("Using st_1 PWL file: %s\n" st1File)
printf("Using st_2 PWL file: %s\n" st2File)

; ------------------------------------------------------------
; Save signals
; ------------------------------------------------------------
; For debugging, save everything. Once this works, replace this
; with a narrower save statement.
; ------------------------------------------------------------

save('all)

; Later, after debugging, you can try something narrower like:
; save("/I56/Iout" "/vpre1" "/vpre")

; ------------------------------------------------------------
; Run simulation
; ------------------------------------------------------------

run()

; ------------------------------------------------------------
; Export selected transient waveforms
; ------------------------------------------------------------

selectResult('tran)

; Retrieve waveforms from transient results.
; This is usually more robust than i("/I56/Iout") for saved signal
; expressions such as those shown in ADE Outputs Setup.

iout_56 = getData("/I56/Iout" ?result 'tran)
vpre1   = getData("/vpre1"    ?result 'tran)
vpre    = getData("/vpre"     ?result 'tran)

; Check that the requested signals were actually found.

unless(iout_56
    error("Could not find transient waveform /I56/Iout. Check the saved signal name and Spectre results.\n")
)

unless(vpre1
    printf("Warning: could not find transient waveform /vpre1.\n")
)

unless(vpre
    printf("Warning: could not find transient waveform /vpre.\n")
)

; Export the current waveform.

ocnPrint(
    ?output strcat(runDir "/output_currents.txt")
    ?precision 10
    ?numSpaces 1
    iout_56
)

; Export voltage waveforms if they exist.

when(vpre1
    ocnPrint(
        ?output strcat(runDir "/output_vpre1.txt")
        ?precision 10
        ?numSpaces 1
        vpre1
    )
)

when(vpre
    ocnPrint(
        ?output strcat(runDir "/output_vpre.txt")
        ?precision 10
        ?numSpaces 1
        vpre
    )
)

printf("Finished test run.\n")
printf("Results directory: %s\n" runDir)
printf("Exported current: %s\n" strcat(runDir "/output_currents.txt"))
printf("Exported vpre1:   %s\n" strcat(runDir "/output_vpre1.txt"))
printf("Exported vpre:    %s\n" strcat(runDir "/output_vpre.txt"))
