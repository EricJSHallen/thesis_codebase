; Batch OCEAN script, use +aps or ++aps for optional performance boost at expense of accuracy. change mt value to adjust multithreading

simulator('spectre)
envOption('userCmdLineOption "++aps +mt=4")

design("sebastian_thesis_pilot" "synapsedualinputtb" "schematic")

; PDK / model library setup
;
; The standalone IPC/OCEAN runs need the Spectre model library explicitly.
; Without this, Spectre reports undefined models/subcircuits such as:
;     ne, pe, cmm4
;
; Defaults are set for your XP018 environment, but they can be overridden
; without editing this file by launching OCEAN with, for example:
;
;     env CAD_PDK_MODEL_FILE=/path/to/model.lib CAD_PDK_MODEL_SECTION=tt ocean ...
;
; If the model library does not use named sections, leave CAD_PDK_MODEL_SECTION
; unset or empty. If it does use sections, set CAD_PDK_MODEL_SECTION to the
; desired corner, e.g. tt, ss, ff, typ, etc.

pdkModelFileStr = getShellEnvVar("CAD_PDK_MODEL_FILE")
pdkModelSectionStr = getShellEnvVar("CAD_PDK_MODEL_SECTION")

pdkModelFile = if(pdkModelFileStr then pdkModelFileStr else "/home/s5117909/eda_env/xp018/xp018_combine.lib")
pdkModelSection = if(pdkModelSectionStr then pdkModelSectionStr else "")

unless(isFile(pdkModelFile)
    error("Cannot find PDK model file: %s\n" pdkModelFile)
)

printf("Using PDK model file: %s\n" pdkModelFile)

if(strlen(pdkModelSection) > 0 then
    printf("Using PDK model section: %s\n" pdkModelSection)
else
    printf("Using PDK model section: <none>\n")
)

; Configure Spectre model file.  Do not pass an empty section string,
; because some OCEAN/ADE versions treat that as an invalid model-file setup.
; If no section is specified, pass only the model-file path.

if(strlen(pdkModelSection) > 0 then
    modelFile(
        list(pdkModelFile pdkModelSection)
    )
else
    modelFile(
        list(pdkModelFile)
    )
)

; User options

; Base directories

baseRepoDir = "/home/s5117909/Documents/thesis/sebastian_thesis_repo"
pwlBaseDir = strcat(baseRepoDir "/processing/general_code/spike_train_output")
st1BaseDir = strcat(pwlBaseDir "/st_1")
st2BaseDir = strcat(pwlBaseDir "/st_2")
outputBaseDir = strcat(baseRepoDir "/processing/cadence_extraction/output_single_data")

; Parallel batch splitting options
;
; Default behavior is unchanged: if the shell variables below are not set,
; this script runs the full batch sequentially in one OCEAN process.
;
; To split the batch across multiple independent OCEAN processes, launch one
; process per job index, for example:
;
;   CAD_NUM_JOBS=4 CAD_JOB_INDEX=0 ocean -nograph -restore single_pwl_opt_parallel.ocn > ocean_job0.log 2>&1 &
;   CAD_NUM_JOBS=4 CAD_JOB_INDEX=1 ocean -nograph -restore single_pwl_opt_parallel.ocn > ocean_job1.log 2>&1 &
;   CAD_NUM_JOBS=4 CAD_JOB_INDEX=2 ocean -nograph -restore single_pwl_opt_parallel.ocn > ocean_job2.log 2>&1 &
;   CAD_NUM_JOBS=4 CAD_JOB_INDEX=3 ocean -nograph -restore single_pwl_opt_parallel.ocn > ocean_job3.log 2>&1 &
;   wait
;
; CAD_NUM_JOBS is the total number of parallel OCEAN processes.
; CAD_JOB_INDEX is the zero-based index of this specific process.
; Each process runs only the cases where mod(runSerial, CAD_NUM_JOBS)
; equals CAD_JOB_INDEX.

numJobsStr  = getShellEnvVar("CAD_NUM_JOBS")
jobIndexStr = getShellEnvVar("CAD_JOB_INDEX")

numJobs = if(numJobsStr then atoi(numJobsStr) else 1)
jobIndex = if(jobIndexStr then atoi(jobIndexStr) else 0)

when(numJobs < 1
    error("CAD_NUM_JOBS must be >= 1\n")
)

when(jobIndex < 0 || jobIndex >= numJobs
    error("CAD_JOB_INDEX must satisfy 0 <= CAD_JOB_INDEX < CAD_NUM_JOBS\n")
)

; Counts valid st1/st2/trial combinations. This counter is used for
; deterministic round-robin distribution across OCEAN processes.
runSerial = 0
assignedRunCount = 0
skippedRunCount = 0

printf("Parallel split: job %d of %d\n" jobIndex numJobs)

unless(isDir(outputBaseDir)
    system(strcat("mkdir -p \"" outputBaseDir "\""))
)

; Analysis

analysis('tran ?stop "1s")

; Define ordinary design variables

desVar("m2l"   180n)
desVar("m2ltb" 180n)
desVar("m2w"   180n)
desVar("m2wtb" 180n)
desVar("m3l" 180n)
desVar("m3w" 180n)
desVar("m4l"   180n)
desVar("m4ltb" 180n)
desVar("m4w"   180n)
desVar("m4wtb" 180n)
desVar("m5l" 180n)
desVar("m5w" 180n)
desVar("pw"   100u)
desVar("T"    1m)
desVar("Vin"  0)
desVar("Vtau" 1.6)
desVar("Vthr" 0.9)
desVar("Vw"   0.5)
desVar("vmax" 1.8)

save('i "/I56/Iout")
save('v "/vpre")
save('v "/vpre1")

; Sanity checks

unless(isDir(st1BaseDir)
    error("Cannot find st_1 directory: %s\n" st1BaseDir)
)

unless(isDir(st2BaseDir)
    error("Cannot find st_2 directory: %s\n" st2BaseDir)
)

; Get directory lists

st1FreqDirs = getDirFiles(st1BaseDir)
st2FreqDirs = getDirFiles(st2BaseDir)

printf("Frequency mixing: enabled\n")
printf("Trial mixing: disabled; only matching trial_N files are paired\n")

; Manifest file

manifestPath = strcat(
    outputBaseDir
    "/run_manifest_job_"
    sprintf(nil "%d" jobIndex)
    "_of_"
    sprintf(nil "%d" numJobs)
    ".csv"
)
manifestPort = outfile(manifestPath "w")

fprintf(
    manifestPort
    "run_name,st1_frequency,st2_frequency,trial_file,st1_file,st2_file,run_dir\n"
)

; Main batch loop

foreach(st1FreqDirName st1FreqDirs

    when(st1FreqDirName != "." && st1FreqDirName != ".."

        st1FreqDir = strcat(st1BaseDir "/" st1FreqDirName)

        when(isDir(st1FreqDir)

            foreach(st2FreqDirName st2FreqDirs

                when(st2FreqDirName != "." && st2FreqDirName != ".."

                    st2FreqDir = strcat(st2BaseDir "/" st2FreqDirName)

                    when(isDir(st2FreqDir)

                        st1TrialFiles = getDirFiles(st1FreqDir)

                        foreach(trialFile st1TrialFiles

                            when(rexMatchp("\\.pwl$" trialFile)

                                st1File = strcat(st1FreqDir "/" trialFile)
                                st2File = strcat(st2FreqDir "/" trialFile)

                                if(isFile(st1File) && isFile(st2File) then

                                    ; Remove ".pwl" from trial filename.
                                    trialStem = substring(
                                        trialFile
                                        1
                                        difference(strlen(trialFile) 4)
                                    )

                                    ; Example:
                                    ; st1_1_hz__st2_100_hz__trial_1
                                    runName = strcat(
                                        "st1_"
                                        st1FreqDirName
                                        "__st2_"
                                        st2FreqDirName
                                        "__"
                                        trialStem
                                    )

                                    runDir = strcat(outputBaseDir "/" runName)

                                    ; Decide whether this OCEAN process owns this simulation.
                                    ; The valid simulation cases are distributed round-robin
                                    ; across CAD_NUM_JOBS independent OCEAN processes.

                                    thisRunSerial = runSerial
                                    runSerial = plus(runSerial 1)

                                    if(mod(thisRunSerial numJobs) == jobIndex then

                                        assignedRunCount = plus(assignedRunCount 1)

                                        unless(isDir(runDir)
                                            system(strcat("mkdir -p \"" runDir "\""))
                                        )

                                        fprintf(
                                            manifestPort
                                            "%s,%s,%s,%s,%s,%s,%s\n"
                                            runName
                                            st1FreqDirName
                                            st2FreqDirName
                                            trialFile
                                            st1File
                                            st2File
                                            runDir
                                        )

                                        ; Send Spectre result database to this run-specific directory.
                                        currentResultsDir = runDir
                                        resultsDir(currentResultsDir)

                                        ; Set PWL-file design variables
                                        ; Important:
                                        ; File paths need embedded quotation marks so Spectre
                                        ; receives them as string parameters.

                                        desVar("pwlFile_st1" strcat("\"" st1File "\""))
                                        desVar("pwlFile_st2" strcat("\"" st2File "\""))

                                        ; Run simulation

                                        run()

                                        ; Export current and voltage waveforms

                                        selectResult('tran)

                                        iout_56  = i("/I56/Iout")
                                        vpre  = v("/vpre")
                                        vpre1 = v("/vpre1")

                                        ocnPrint(
                                            ?output strcat(runDir "/output_signals.txt")
                                            ?precision 10
                                            ?numSpaces 1
                                            iout_56
                                            vpre
                                            vpre1
                                        )

                                        ; Close results. Your Cadence/OCEAN version requires one argument
                                        ; for closeResults(), hence:
                                        ;     closeResults(currentResultsDir)
                                        ; rather than:
                                        ;     closeResults()

                                        closeResults(currentResultsDir)

                                        printf("Finished: %s\n" runName)

                                    else

                                        skippedRunCount = plus(skippedRunCount 1)

                                    )

                                else

                                    ; This is not necessarily an error.
                                    ; It simply means the same trial file does not exist
                                    ; in this st_2 frequency directory.

                                    when(isFile(st1File) && !isFile(st2File)
                                        warn(
                                            "Skipping st1=%s with st2 frequency=%s because matching trial is missing: %s\n"
                                            st1File
                                            st2FreqDirName
                                            st2File
                                        )
                                    )
                                )
                            )
                        )
                    )
                )
            )
        )
    )
)

close(manifestPort)

printf("Finished assigned simulations for job %d of %d.\n" jobIndex numJobs)
printf("Total valid cases seen by this process: %d\n" runSerial)
printf("Cases assigned to this process: %d\n" assignedRunCount)
printf("Cases skipped by this process: %d\n" skippedRunCount)
printf("Manifest written to: %s\n" manifestPath)
printf("Output base directory: %s\n" outputBaseDir)

; Optional batch-mode exit. Set CAD_BATCH_EXIT=1 only for standalone ocean -nograph runs.
batchExitStr = getShellEnvVar("CAD_BATCH_EXIT")

when(batchExitStr == "1"
    printf("CAD_BATCH_EXIT=1, exiting OCEAN.\n")
    exit()
)
