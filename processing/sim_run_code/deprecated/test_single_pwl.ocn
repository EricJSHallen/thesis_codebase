; Batch OCEAN script, use +aps or ++aps for optional performance boost at expense of accuracy. change mt value to adjust multithreading

simulator('spectre)
envOption('userCmdLineOption "+aps +mt=2")

design("sebastian_thesis_pilot" "synapsedualinputtb" "schematic")

; User options

; Base directories

baseRepoDir = "/home/s5117909/Documents/thesis/sebastian_thesis_repo"
pwlBaseDir = strcat(baseRepoDir "/processing/general_code/spike_train_output")
st1BaseDir = strcat(pwlBaseDir "/st_1")
st2BaseDir = strcat(pwlBaseDir "/st_2")
outputBaseDir = strcat(baseRepoDir "/processing/cadence_extraction/output_single_data")

unless(isDir(outputBaseDir)
    system(strcat("mkdir -p \"" outputBaseDir "\""))
)

; Analysis

analysis('tran ?stop "1s")

; Define ordinary design variables

desVar("m2l"   180n)
desVar("m2ltb" 180n)
desVar("m2w"   180n)
desVar("m2wtb" 180n)
desVar("m3l" 180n)
desVar("m3w" 180n)
desVar("m4l"   180n)
desVar("m4ltb" 180n)
desVar("m4w"   180n)
desVar("m4wtb" 180n)
desVar("m5l" 180n)
desVar("m5w" 180n)
desVar("pw"   100u)
desVar("T"    1m)
desVar("Vin"  0)
desVar("Vtau" 1.6)
desVar("Vthr" 0.9)
desVar("Vw"   0.5)
desVar("vmax" 1.8)

save('i "/I56/Iout")
save('v "/vpre")
save('v "/vpre1")

; Sanity checks

unless(isDir(st1BaseDir)
    error("Cannot find st_1 directory: %s\n" st1BaseDir)
)

unless(isDir(st2BaseDir)
    error("Cannot find st_2 directory: %s\n" st2BaseDir)
)

; Get directory lists

st1FreqDirs = getDirFiles(st1BaseDir)
st2FreqDirs = getDirFiles(st2BaseDir)

printf("Frequency mixing: enabled\n")
printf("Trial mixing: disabled; only matching trial_N files are paired\n")

; Manifest file

manifestPath = strcat(outputBaseDir "/run_manifest.csv")
manifestPort = outfile(manifestPath "w")

fprintf(
    manifestPort
    "run_name,st1_frequency,st2_frequency,trial_file,st1_file,st2_file,run_dir\n"
)

; Main batch loop

foreach(st1FreqDirName st1FreqDirs

    when(st1FreqDirName != "." && st1FreqDirName != ".."

        st1FreqDir = strcat(st1BaseDir "/" st1FreqDirName)

        when(isDir(st1FreqDir)

            foreach(st2FreqDirName st2FreqDirs

                when(st2FreqDirName != "." && st2FreqDirName != ".."

                    st2FreqDir = strcat(st2BaseDir "/" st2FreqDirName)

                    when(isDir(st2FreqDir)

                        st1TrialFiles = getDirFiles(st1FreqDir)

                        foreach(trialFile st1TrialFiles

                            when(rexMatchp("\\.pwl$" trialFile)

                                st1File = strcat(st1FreqDir "/" trialFile)
                                st2File = strcat(st2FreqDir "/" trialFile)

                                if(isFile(st1File) && isFile(st2File) then

                                    ; Remove ".pwl" from trial filename.
                                    trialStem = substring(
                                        trialFile
                                        1
                                        difference(strlen(trialFile) 4)
                                    )

                                    ; Example:
                                    ; st1_1_hz__st2_100_hz__trial_1
                                    runName = strcat(
                                        "st1_"
                                        st1FreqDirName
                                        "__st2_"
                                        st2FreqDirName
                                        "__"
                                        trialStem
                                    )

                                    runDir = strcat(outputBaseDir "/" runName)

                                    unless(isDir(runDir)
                                        system(strcat("mkdir -p \"" runDir "\""))
                                    )

                                    ; Send Spectre result database to this run-specific directory.
                                    currentResultsDir = runDir
                                    resultsDir(currentResultsDir)

                                    ; Set PWL-file design variables
                                    ; Important:
                                    ; File paths need embedded quotation marks so Spectre
                                    ; receives them as string parameters.

                                    desVar("pwlFile_st1" strcat("\"" st1File "\""))
                                    desVar("pwlFile_st2" strcat("\"" st2File "\""))

                                    fprintf(
                                        manifestPort
                                        "%s,%s,%s,%s,%s,%s,%s\n"
                                        runName
                                        st1FreqDirName
                                        st2FreqDirName
                                        trialFile
                                        st1File
                                        st2File
                                        runDir
                                    )

                                    ; Run simulation

                                    run()

                                    ; Export current and voltage waveforms

                                    selectResult('tran)

                                    iout_56  = i("/I56/Iout")
                                    vpre  = v("/vpre")
                                    vpre1 = v("/vpre1")

                                    ocnPrint(
                                        ?output strcat(runDir "/output_signals.txt")
                                        ?precision 10
                                        ?numSpaces 1
                                        iout_56
                                        vpre
                                        vpre1
                                    )

                                    ; Close results. Your Cadence/OCEAN version requires one argument
                                    ; for closeResults(), hence:
                                    ;     closeResults(currentResultsDir)
                                    ; rather than:
                                    ;     closeResults()

                                    closeResults(currentResultsDir)

                                    printf("Finished: %s\n" runName)

                                else

                                    ; This is not necessarily an error.
                                    ; It simply means the same trial file does not exist
                                    ; in this st_2 frequency directory.

                                    when(isFile(st1File) && !isFile(st2File)
                                        warn(
                                            "Skipping st1=%s with st2 frequency=%s because matching trial is missing: %s\n"
                                            st1File
                                            st2FreqDirName
                                            st2File
                                        )
                                    )
                                )
                            )
                        )
                    )
                )
            )
        )
    )
)

close(manifestPort)

printf("Finished all simulations.\n")
printf("Manifest written to: %s\n" manifestPath)
printf("Output base directory: %s\n" outputBaseDir)
