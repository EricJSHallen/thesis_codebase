; ============================================================
; Batch OCEAN script
; Mix st_1 and st_2 frequencies, but keep matching trials
;
; Example included:
;     st_1/1_hz/trial_1.pwl with st_2/100_hz/trial_1.pwl
;
; Example excluded:
;     st_1/1_hz/trial_1.pwl with st_2/100_hz/trial_3.pwl
;
; Exports:
;     i("/I172/Iout")
;     i("/I56/Iout")
;     v("/vpre")
;     v("/vpre1")
;
; By default, deletes the PSF directory after output_signals.txt
; is written.
; ============================================================

simulator('spectre)

; ------------------------------------------------------------
; Design under test
; ------------------------------------------------------------

design("sebastian_thesis_pilot" "dynapsetb1" "schematic")

; ------------------------------------------------------------
; User options
; ------------------------------------------------------------

; Set to t if you want to keep full PSF simulation databases.
; Set to nil if you only want output_signals.txt.
keepPsf = nil

; ------------------------------------------------------------
; Base directories
; ------------------------------------------------------------

baseRepoDir = "/home/s5117909/Documents/thesis/sebastian_thesis_repo"

pwlBaseDir = strcat(baseRepoDir "/processing/general_code/spike_train_output")

st1BaseDir = strcat(pwlBaseDir "/st_1")
st2BaseDir = strcat(pwlBaseDir "/st_2")

outputBaseDir = strcat(baseRepoDir "/processing/cadence_extraction/output_duo_data")

unless(isDir(outputBaseDir)
    system(strcat("mkdir -p \"" outputBaseDir "\""))
)

; ------------------------------------------------------------
; Analysis
; ------------------------------------------------------------

analysis('tran ?stop "1s")

; ------------------------------------------------------------
; Define ordinary design variables
; ------------------------------------------------------------

desVar("ml" 180n)
desVar("mw" 180n)

desVar("m2l"   180n)
desVar("m2ltb" 180n)
desVar("m2w"   180n)
desVar("m2wtb" 180n)

desVar("m3l" 180n)
desVar("m3w" 180n)

desVar("m4l"   180n)
desVar("m4ltb" 180n)
desVar("m4w"   180n)
desVar("m4wtb" 180n)

desVar("m5l" 180n)
desVar("m5w" 180n)

desVar("pw"   100u)
desVar("T"    1m)
desVar("Vin"  0)
desVar("Vtau" 1.6)
desVar("Vthr" 0.9)
desVar("Vw"   0.5)
desVar("vmax" 1.8)

; ------------------------------------------------------------
; Save requested currents and voltages
; ------------------------------------------------------------

save('i "/I172/Iout")
save('i "/I56/Iout")

save('v "/vpre")
save('v "/vpre1")

; ------------------------------------------------------------
; Sanity checks
; ------------------------------------------------------------

unless(isDir(st1BaseDir)
    error("Cannot find st_1 directory: %s\n" st1BaseDir)
)

unless(isDir(st2BaseDir)
    error("Cannot find st_2 directory: %s\n" st2BaseDir)
)

; ------------------------------------------------------------
; Get directory lists
; ------------------------------------------------------------

st1FreqDirs = getDirFiles(st1BaseDir)
st2FreqDirs = getDirFiles(st2BaseDir)

; ------------------------------------------------------------
; Pre-count total number of simulations
; ------------------------------------------------------------
; This lets us print a useful progress percentage.

totalRuns = 0

foreach(st1FreqDirName st1FreqDirs

    when(st1FreqDirName != "." && st1FreqDirName != ".."

        st1FreqDir = strcat(st1BaseDir "/" st1FreqDirName)

        when(isDir(st1FreqDir)

            foreach(st2FreqDirName st2FreqDirs

                when(st2FreqDirName != "." && st2FreqDirName != ".."

                    st2FreqDir = strcat(st2BaseDir "/" st2FreqDirName)

                    when(isDir(st2FreqDir)

                        st1TrialFiles = getDirFiles(st1FreqDir)

                        foreach(trialFile st1TrialFiles

                            when(rexMatchp("\\.pwl$" trialFile)

                                st1File = strcat(st1FreqDir "/" trialFile)
                                st2File = strcat(st2FreqDir "/" trialFile)

                                when(isFile(st1File) && isFile(st2File)
                                    totalRuns = totalRuns + 1
                                )
                            )
                        )
                    )
                )
            )
        )
    )
)

printf("============================================================\n")
printf("Total simulations to run: %d\n" totalRuns)
printf("Frequency mixing: enabled\n")
printf("Trial mixing: disabled; only matching trial_N files are paired\n")
printf("keepPsf: %L\n" keepPsf)
printf("============================================================\n")

when(totalRuns == 0
    error("No valid st_1/st_2 matching-trial PWL combinations found.\n")
)

; ------------------------------------------------------------
; Manifest file
; ------------------------------------------------------------

manifestPath = strcat(outputBaseDir "/run_manifest.csv")
manifestPort = outfile(manifestPath "w")

fprintf(
    manifestPort
    "run_index,total_runs,progress_percent,run_name,st1_frequency,st2_frequency,trial_file,st1_file,st2_file,run_dir,keep_psf\n"
)

; ------------------------------------------------------------
; Main batch loop
; ------------------------------------------------------------

runCount = 0

foreach(st1FreqDirName st1FreqDirs

    when(st1FreqDirName != "." && st1FreqDirName != ".."

        st1FreqDir = strcat(st1BaseDir "/" st1FreqDirName)

        when(isDir(st1FreqDir)

            foreach(st2FreqDirName st2FreqDirs

                when(st2FreqDirName != "." && st2FreqDirName != ".."

                    st2FreqDir = strcat(st2BaseDir "/" st2FreqDirName)

                    when(isDir(st2FreqDir)

                        st1TrialFiles = getDirFiles(st1FreqDir)

                        foreach(trialFile st1TrialFiles

                            when(rexMatchp("\\.pwl$" trialFile)

                                st1File = strcat(st1FreqDir "/" trialFile)
                                st2File = strcat(st2FreqDir "/" trialFile)

                                if(isFile(st1File) && isFile(st2File) then

                                    ; Remove ".pwl" from trial filename.
                                    trialStem = substring(
                                        trialFile
                                        1
                                        difference(strlen(trialFile) 4)
                                    )

                                    runCount = runCount + 1

                                    progressPercent = 100.0 * runCount / totalRuns

                                    ; Example:
                                    ; st1_1_hz__st2_100_hz__trial_1
                                    runName = strcat(
                                        "st1_"
                                        st1FreqDirName
                                        "__st2_"
                                        st2FreqDirName
                                        "__"
                                        trialStem
                                    )

                                    runDir = strcat(outputBaseDir "/" runName)

                                    unless(isDir(runDir)
                                        system(strcat("mkdir -p \"" runDir "\""))
                                    )

                                    ; Send Spectre result database to this run-specific directory.
                                    currentResultsDir = runDir
                                    resultsDir(currentResultsDir)

                                    ; ------------------------------------------------
                                    ; Set PWL-file design variables
                                    ; ------------------------------------------------
                                    ; Important:
                                    ; File paths need embedded quotation marks so Spectre
                                    ; receives them as string parameters.

                                    desVar("pwlFile_st1" strcat("\"" st1File "\""))
                                    desVar("pwlFile_st2" strcat("\"" st2File "\""))

                                    printf("============================================================\n")
                                    printf(
                                        "Progress: %d / %d  %.2f%%\n"
                                        runCount
                                        totalRuns
                                        progressPercent
                                    )
                                    printf("Running: %s\n" runName)
                                    printf("  st_1 PWL: %s\n" st1File)
                                    printf("  st_2 PWL: %s\n" st2File)
                                    printf("  output:   %s\n" runDir)
                                    printf("  keepPsf:  %L\n" keepPsf)

                                    fprintf(
                                        manifestPort
                                        "%d,%d,%.6f,%s,%s,%s,%s,%s,%s,%s,%L\n"
                                        runCount
                                        totalRuns
                                        progressPercent
                                        runName
                                        st1FreqDirName
                                        st2FreqDirName
                                        trialFile
                                        st1File
                                        st2File
                                        runDir
                                        keepPsf
                                    )

                                    ; ------------------------------------------------
                                    ; Run simulation
                                    ; ------------------------------------------------

                                    run()

                                    ; ------------------------------------------------
                                    ; Export current and voltage waveforms
                                    ; ------------------------------------------------

                                    selectResult('tran)

                                    iout_172 = i("/I172/Iout")
                                    iout_56  = i("/I56/Iout")

                                    vpre  = v("/vpre")
                                    vpre1 = v("/vpre1")

                                    ocnPrint(
                                        ?output strcat(runDir "/output_signals.txt")
                                        ?precision 10
                                        ?numSpaces 1
                                        iout_172
                                        iout_56
                                        vpre
                                        vpre1
                                    )

                                    ; ------------------------------------------------
                                    ; Close results before deleting PSF
                                    ; ------------------------------------------------
                                    ; Your Cadence/OCEAN version requires one argument
                                    ; for closeResults(), hence:
                                    ;
                                    ;     closeResults(currentResultsDir)
                                    ;
                                    ; rather than:
                                    ;
                                    ;     closeResults()

                                    closeResults(currentResultsDir)

                                    ; Optional small delay, useful if the filesystem is slow
                                    ; to release files after Spectre/OCEAN closes them.
                                    sleep(1)

                                    ; ------------------------------------------------
                                    ; Optionally delete PSF data
                                    ; ------------------------------------------------

                                    unless(keepPsf

                                        psfDir = strcat(runDir "/psf")

                                        when(isDir(psfDir)
                                            printf("Deleting PSF directory: %s\n" psfDir)
                                            system(strcat("rm -rf \"" psfDir "\""))
                                        )
                                    )

                                    printf("Finished: %s\n" runName)

                                else

                                    ; This is not necessarily an error.
                                    ; It simply means the same trial file does not exist
                                    ; in this st_2 frequency directory.

                                    when(isFile(st1File) && !isFile(st2File)
                                        warn(
                                            "Skipping st1=%s with st2 frequency=%s because matching trial is missing: %s\n"
                                            st1File
                                            st2FreqDirName
                                            st2File
                                        )
                                    )
                                )
                            )
                        )
                    )
                )
            )
        )
    )
)

close(manifestPort)

printf("============================================================\n")
printf("Finished all simulations.\n")
printf("Total completed runs: %d / %d\n" runCount totalRuns)
printf("Manifest written to: %s\n" manifestPath)
printf("Output base directory: %s\n" outputBaseDir)
printf("keepPsf = %L\n" keepPsf)
printf("============================================================\n")
