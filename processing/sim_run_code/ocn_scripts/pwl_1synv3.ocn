; Batch OCEAN script, use +aps or ++aps for optional performance boost at expense of accuracy. change mt value to adjust multithreading
; This script has been modded from the last one to include variability in the number of Jobs that are being used, and to be more robust on failure.

simulator('spectre)
envOption('userCmdLineOption "++aps +mt=4")
option('redefinedparams "warning")

design("sebastian_thesis_pilot" "synapsedualinputtb" "schematic")

; Spectre model-library setup
;
; These entries are copied from the working ADE "Model Libraries" view.
; IMPORTANT: modelFile() expects each model entry as a separate argument.
; Therefore the modelFileList below is expanded with apply(). Passing the
; list-of-lists directly as modelFile(modelFileList) does not install the
; model libraries correctly in OCEAN.

modelConfig = "/projects/bics/designkits/xfab/xp018/cadence/v8_0/spectre/v8_0_1/lp5mos/config.scs"
modelParam  = "/projects/bics/designkits/xfab/xp018/cadence/v8_0/spectre/v8_0_1/lp5mos/param.scs"
modelBip    = "/projects/bics/designkits/xfab/xp018/cadence/v8_0/spectre/v8_0_1/lp5mos/bip.scs"
modelCap    = "/projects/bics/designkits/xfab/xp018/cadence/v8_0/spectre/v8_0_1/lp5mos/cap.scs"
modelDio    = "/projects/bics/designkits/xfab/xp018/cadence/v8_0/spectre/v8_0_1/lp5mos/dio.scs"
modelMos    = "/projects/bics/designkits/xfab/xp018/cadence/v8_0/spectre/v8_0_1/lp5mos/mos.scs"
modelRes    = "/projects/bics/designkits/xfab/xp018/cadence/v8_0/spectre/v8_0_1/lp5mos/res.scs"
modelXp018  = "/projects/bics/designkits/xfab/xp018/cadence/v8_0/spectre/v8_0_1/lp5mos/xp018.scs"

foreach(modelPath list(modelConfig modelParam modelBip modelCap modelDio modelMos modelRes)
    unless(isFile(modelPath)
        error("Cannot find Spectre model file: %s\n" modelPath)
    )
)

printf("Using ADE Spectre model libraries from XP018 lp5mos via apply(modelFile ...).\n")

modelFileList = list(
    list(modelConfig "default")
    list(modelParam  "3s")
    list(modelBip    "tm")
    list(modelCap    "tm")
    list(modelDio    "tm")
    list(modelMos    "tm")
    list(modelRes    "tm")
)

apply('modelFile modelFileList)

; User options

; Base directories

baseRepoDir = "/home/s5117909/Documents/thesis/thesis_codebase"
pwlBaseDir = strcat(baseRepoDir "/processing/sim_run_code/spike_train_output")
st1BaseDir = strcat(pwlBaseDir "/st_1")
st2BaseDir = strcat(pwlBaseDir "/st_2")
 ; Default output directory for direct/manual runs. The setup shell script
; copies this file into thesis_database/<run_id>/ocn/ and patches this line
; to thesis_database/<run_id>/output_2channel_1syn_data.
outputBaseDir = strcat(baseRepoDir "/thesis_database/manual_output_2channel_1syn_data")

; Parallel batch splitting options
;
; USER-SELECTED JOB COUNT:
; Set this one variable to the total number of independent OCEAN processes
; you intend to launch.
;
;   numJobs = 4
;
; Then launch one process for each zero-based CAD_JOB_INDEX:
;
;   CAD_JOB_INDEX=0 ocean -nograph -restore pwl_1syn_resume_atomic_topjobs.ocn > ocean_job0.log 2>&1 &
;   CAD_JOB_INDEX=1 ocean -nograph -restore pwl_1syn_resume_atomic_topjobs.ocn > ocean_job1.log 2>&1 &
;   CAD_JOB_INDEX=2 ocean -nograph -restore pwl_1syn_resume_atomic_topjobs.ocn > ocean_job2.log 2>&1 &
;   CAD_JOB_INDEX=3 ocean -nograph -restore pwl_1syn_resume_atomic_topjobs.ocn > ocean_job3.log 2>&1 &
;   wait
;
; For a fully sequential run from the beginning, set:
;
;   numJobs = 1
;
; and launch without CAD_JOB_INDEX, or with CAD_JOB_INDEX=0.
;
; IMPORTANT:
; If numJobs is 4, you must launch job indices 0, 1, 2, and 3 to cover
; the full batch. Each process runs only cases where mod(runSerial, numJobs)
; equals its job index.

; Number of parallel jobs is supplied by the shell/CIW launch command.
; The setup shell script prints commands containing CAD_NUM_JOBS=<N> and
; CAD_JOB_INDEX=<0..N-1>. If CAD_NUM_JOBS is absent, default to a safe
; sequential run with one job.

numJobsStr = getShellEnvVar("CAD_NUM_JOBS")
numJobs = if(numJobsStr then atoi(numJobsStr) else 1)

; The job index still has to be different for each simultaneously launched
; process. Keeping it as a shell variable avoids needing separate copies
; of this script. If CAD_JOB_INDEX is absent, the default is job 0, which is
; appropriate for numJobs=1 sequential runs.

jobIndexStr = getShellEnvVar("CAD_JOB_INDEX")
jobIndex = if(jobIndexStr then atoi(jobIndexStr) else 0)

when(numJobs < 1
    error("numJobs must be >= 1. Edit the numJobs variable near the top of the script.\n")
)

when(jobIndex < 0 || jobIndex >= numJobs
    error("CAD_JOB_INDEX must satisfy 0 <= CAD_JOB_INDEX < numJobs. Check CAD_JOB_INDEX and the top-of-script numJobs variable.\n")
)

; Counts valid st1/st2/trial combinations. This counter is used for
; deterministic round-robin distribution across OCEAN processes.
runSerial = 0
assignedRunCount = 0
skippedRunCount = 0
alreadyDoneCount = 0
failedOrRunCount = 0

printf("Parallel split: job %d of %d\n" jobIndex numJobs)

unless(isDir(outputBaseDir)
    system(strcat("mkdir -p \"" outputBaseDir "\""))
)

; Analysis

analysis('tran ?stop "0.5s")

; Define ordinary design variables

desVar("m2l"   200n)
desVar("m2ltb" 1.05u)
desVar("m2w"   3u)
desVar("m2wtb" 2.1u)
desVar("m3l" 4u)
desVar("m3w" 2.1u)
desVar("m4l"   1.05u)
desVar("m4ltb" 1.05u)
desVar("m4w"   2.1u)
desVar("m4wtb" 2.1u)
desVar("m5l" 1.05u)
desVar("m5w" 2.1u)
desVar("pw"   100u)
desVar("T"    1m)
desVar("Vin"  0)
desVar("Vtau" 1.6)
desVar("Vthr" 0.9)
desVar("Vw"   0.5)
desVar("vmax" 1.8)
desVar("capacitance" 6p)

save('i "/I56/Iout")
save('v "/vpre")
save('v "/vpre1")

; Sanity checks

unless(isDir(st1BaseDir)
    error("Cannot find st_1 directory: %s\n" st1BaseDir)
)

unless(isDir(st2BaseDir)
    error("Cannot find st_2 directory: %s\n" st2BaseDir)
)

; Get directory lists

st1FreqDirs = getDirFiles(st1BaseDir)
st2FreqDirs = getDirFiles(st2BaseDir)

printf("Frequency mixing: enabled\n")
printf("Trial mixing: disabled; only matching trial_N files are paired\n")

; Manifest file

manifestPath = strcat(
    outputBaseDir
    "/run_manifest_job_"
    sprintf(nil "%d" jobIndex)
    "_of_"
    sprintf(nil "%d" numJobs)
    ".csv"
)
manifestPort = outfile(manifestPath "w")

fprintf(
    manifestPort
    "run_name,st1_frequency,st2_frequency,trial_file,st1_file,st2_file,run_dir\n"
)

; Main batch loop

foreach(st1FreqDirName st1FreqDirs

    when(st1FreqDirName != "." && st1FreqDirName != ".."

        st1FreqDir = strcat(st1BaseDir "/" st1FreqDirName)

        when(isDir(st1FreqDir)

            foreach(st2FreqDirName st2FreqDirs

                when(st2FreqDirName != "." && st2FreqDirName != ".."

                    st2FreqDir = strcat(st2BaseDir "/" st2FreqDirName)

                    when(isDir(st2FreqDir)

                        st1TrialFiles = getDirFiles(st1FreqDir)

                        foreach(trialFile st1TrialFiles

                            when(rexMatchp("\\.pwl$" trialFile)

                                st1File = strcat(st1FreqDir "/" trialFile)
                                st2File = strcat(st2FreqDir "/" trialFile)

                                if(isFile(st1File) && isFile(st2File) then

                                    ; Remove ".pwl" from trial filename.
                                    trialStem = substring(
                                        trialFile
                                        1
                                        difference(strlen(trialFile) 4)
                                    )

                                    ; Example:
                                    ; st1_1_hz__st2_100_hz__trial_1
                                    runName = strcat(
                                        "st1_"
                                        st1FreqDirName
                                        "__st2_"
                                        st2FreqDirName
                                        "__"
                                        trialStem
                                    )

                                    runDir = strcat(outputBaseDir "/" runName)

                                    ; Decide whether this OCEAN process owns this simulation.
                                    ; The valid simulation cases are distributed round-robin
                                    ; across numJobs independent OCEAN processes.

                                    thisRunSerial = runSerial
                                    runSerial = plus(runSerial 1)

                                    if(mod(thisRunSerial numJobs) == jobIndex then

                                        assignedRunCount = plus(assignedRunCount 1)

                                        unless(isDir(runDir)
                                            system(strcat("mkdir -p \"" runDir "\""))
                                        )

                                        outputSignalsFile = strcat(runDir "/output_signals.txt")
                                        outputSignalsTmp  = strcat(runDir "/output_signals.txt.tmp")

                                        if(isFile(outputSignalsFile) then

                                            ; Resume mode: this case already has the exported data file.
                                            ; Do not rerun it. This is useful after logout/key-expiry interruption.

                                            alreadyDoneCount = plus(alreadyDoneCount 1)
                                            printf("Skipping existing completed output: %s\n" runName)

                                        else

                                            failedOrRunCount = plus(failedOrRunCount 1)

                                            fprintf(
                                                manifestPort
                                                "%s,%s,%s,%s,%s,%s,%s\n"
                                                runName
                                                st1FreqDirName
                                                st2FreqDirName
                                                trialFile
                                                st1File
                                                st2File
                                                runDir
                                            )

                                            ; Send Spectre result database to this run-specific directory.
                                            currentResultsDir = runDir
                                            resultsDir(currentResultsDir)

                                            ; Set PWL-file design variables
                                            ; Important:
                                            ; File paths need embedded quotation marks so Spectre
                                            ; receives them as string parameters.

                                            desVar("pwlFile_st1" strcat("\"" st1File "\""))
                                            desVar("pwlFile_st2" strcat("\"" st2File "\""))

                                            ; Run simulation

                                            run()

                                            ; Export current and voltage waveforms

                                            selectResult('tran)

                                            iout_56  = i("/I56/Iout")
                                            vpre  = v("/vpre")
                                            vpre1 = v("/vpre1")

                                            ; Atomic-ish export for resume safety:
                                            ; write to a temporary file first, then rename it to
                                            ; output_signals.txt only after ocnPrint() completes.
                                            ; This prevents an interrupted ocnPrint() from leaving a
                                            ; partial final output file that resume mode would later skip.

                                            when(isFile(outputSignalsTmp)
                                                system(strcat("rm -f \"" outputSignalsTmp "\""))
                                            )

                                            ocnPrint(
                                                ?output outputSignalsTmp
                                                ?precision 10
                                                ?numSpaces 1
                                                iout_56
                                                vpre
                                                vpre1
                                            )

                                            system(strcat("mv -f \"" outputSignalsTmp "\" \"" outputSignalsFile "\""))

                                            ; Close results. Your Cadence/OCEAN version requires one argument
                                            ; for closeResults(), hence:
                                            ;     closeResults(currentResultsDir)
                                            ; rather than:
                                            ;     closeResults()

                                            closeResults(currentResultsDir)

                                            printf("Finished: %s\n" runName)

                                        )

                                    else

                                        skippedRunCount = plus(skippedRunCount 1)

                                    )

                                else

                                    ; This is not necessarily an error.
                                    ; It simply means the same trial file does not exist
                                    ; in this st_2 frequency directory.

                                    when(isFile(st1File) && !isFile(st2File)
                                        warn(
                                            "Skipping st1=%s with st2 frequency=%s because matching trial is missing: %s\n"
                                            st1File
                                            st2FreqDirName
                                            st2File
                                        )
                                    )
                                )
                            )
                        )
                    )
                )
            )
        )
    )
)

close(manifestPort)

printf("Finished assigned simulations for job %d of %d.\n" jobIndex numJobs)
printf("Total valid cases seen by this process: %d\n" runSerial)
printf("Cases assigned to this process: %d\n" assignedRunCount)
printf("Cases skipped by this process: %d\n" skippedRunCount)
printf("Cases already completed and skipped by resume mode: %d\n" alreadyDoneCount)
printf("Cases newly attempted by this process: %d\n" failedOrRunCount)
printf("Manifest written to: %s\n" manifestPath)
printf("Output base directory: %s\n" outputBaseDir)

; Optional clean exit for standalone IPC/batch OCEAN launches.
batchExitStr = getShellEnvVar("CAD_BATCH_EXIT")
when(batchExitStr == "1"
    printf("CAD_BATCH_EXIT=1, exiting OCEAN.\n")
    exit()
)
