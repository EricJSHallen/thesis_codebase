; ============================================================
; Minimal OCEAN test script
; Test one pair of PWL files and debug transient output names
; ============================================================

simulator('spectre)

; ------------------------------------------------------------
; Design under test
; ------------------------------------------------------------

design("sebastian_thesis_pilot" "synapsedualinputtb" "schematic")

; ------------------------------------------------------------
; Directory setup
; ------------------------------------------------------------

baseRepoDir = "/home/s5117909/Documents/thesis/sebastian_thesis_repo"

pwlBaseDir = strcat(baseRepoDir "/processing/general_code/spike_train_output")

outputBaseDir = strcat(baseRepoDir "/processing/cadence_extraction/testoutput")

runName = "test"
runDir = strcat(outputBaseDir "/" runName)

unless(isDir(outputBaseDir)
    system(strcat("mkdir -p " outputBaseDir))
)

unless(isDir(runDir)
    system(strcat("mkdir -p " runDir))
)

resultsDir(runDir)

; ------------------------------------------------------------
; Analysis
; ------------------------------------------------------------

analysis('tran ?stop "1s")

; ------------------------------------------------------------
; Design variables
; ------------------------------------------------------------

desVar("ml" 180n)
desVar("mw" 180n)

desVar("m2l"   180n)
desVar("m2ltb" 180n)
desVar("m2w"   180n)
desVar("m2wtb" 180n)

desVar("m3l" 180n)
desVar("m3w" 180n)

desVar("m4l"   180n)
desVar("m4ltb" 180n)
desVar("m4w"   180n)
desVar("m4wtb" 180n)

desVar("m5l" 180n)
desVar("m5w" 180n)

desVar("pw"   100u)
desVar("T"    1m)
desVar("Vin"  0)
desVar("Vtau" 1.7)
desVar("Vthr" 0.6)
desVar("Vw"   1.0)
desVar("vmax" 1.8)

; ------------------------------------------------------------
; PWL design variables
; ------------------------------------------------------------

st1File = strcat(pwlBaseDir "/st_1/600_hz/trial_1.pwl")
st2File = strcat(pwlBaseDir "/st_2/600_hz/trial_1.pwl")

unless(isFile(st1File)
    error("Cannot find st_1 PWL file: %s\n" st1File)
)

unless(isFile(st2File)
    error("Cannot find st_2 PWL file: %s\n" st2File)
)

desVar("pwlFile_st1" strcat("\"" st1File "\""))
desVar("pwlFile_st2" strcat("\"" st2File "\""))

printf("Using st_1 PWL file: %s\n" st1File)
printf("Using st_2 PWL file: %s\n" st2File)

; ------------------------------------------------------------
; Save signals
; ------------------------------------------------------------
; During debugging, save broadly.
; This makes it easier to determine the actual PSF waveform names.
; ------------------------------------------------------------

save('all)

; Also explicitly request the current expression shown in ADE.
; This may or may not be the exact internal PSF name, but it is worth keeping.

save('i "/I56/Iout")

; ------------------------------------------------------------
; Run simulation
; ------------------------------------------------------------

run()

; ------------------------------------------------------------
; Inspect transient result
; ------------------------------------------------------------

selectResult('tran)

printf("Available results:\n")
results()

printf("Available transient outputs:\n")
outputs()

; Save the list of transient outputs to a text file for inspection.

outputListFile = strcat(runDir "/available_tran_outputs.txt")

ocnPrint(
    ?output outputListFile
    outputs()
)

printf("Wrote available transient outputs to: %s\n" outputListFile)

; ------------------------------------------------------------
; Try several likely names for the current
; ------------------------------------------------------------
; Different Cadence/Spectre setups can expose terminal currents
; with different path syntaxes. We test several common variants.
; ------------------------------------------------------------

iout_56 = nil

when(iout_56 == nil
    iout_56 = getData("/I56/Iout" ?result 'tran)
)

when(iout_56 == nil
    iout_56 = getData("I56:Iout" ?result 'tran)
)

when(iout_56 == nil
    iout_56 = getData("/I56:Iout" ?result 'tran)
)

when(iout_56 == nil
    iout_56 = getData("I56/Iout" ?result 'tran)
)

when(iout_56 == nil
    iout_56 = i("/I56/Iout")
)

when(iout_56 == nil
    iout_56 = i("I56:Iout")
)

; ------------------------------------------------------------
; Export current if found
; ------------------------------------------------------------

if(iout_56 then
    ocnPrint(
        ?output strcat(runDir "/output_currents.txt")
        ?precision 10
        ?numSpaces 1
        iout_56
    )

    printf("Exported current to: %s\n" strcat(runDir "/output_currents.txt"))

else
    printf("Could not find current waveform for /I56/Iout.\n")
    printf("Check this file for the actual saved names:\n")
    printf("%s\n" outputListFile)

    error("Current waveform not found. Inspect available_tran_outputs.txt.\n")
)

printf("Finished test run.\n")
printf("Results directory: %s\n" runDir)
