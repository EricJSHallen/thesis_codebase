; export_psf_to_txt_reorg_v3.ocn
; Opens one plain-Spectre PSF result directory and writes output_signals.txt.

caseDir = getShellEnvVar("CAD_CASE_DIR")
unless(caseDir
  error("CAD_CASE_DIR is not set.\n")
)

psfDir  = strcat(caseDir "/psf")
outTmp  = strcat(caseDir "/output_signals.txt.tmp")
outFile = strcat(caseDir "/output_signals.txt")

unless(isDir(psfDir)
  error("Cannot find PSF directory: %s\n" psfDir)
)

openResults(psfDir)
selectResult('tran)

iout_56 = i("/I56/Iout")
vpre    = v("/vpre")
vpre1   = v("/vpre1")

when(isFile(outTmp)
  system(strcat("rm -f \"" outTmp "\""))
)

ocnPrint(?output outTmp ?precision 10 ?numSpaces 1 iout_56 vpre vpre1)
system(strcat("mv -f \"" outTmp "\" \"" outFile "\""))

closeResults(psfDir)
printf("Wrote %s\n" outFile)

batchExitStr = getShellEnvVar("CAD_BATCH_EXIT")
when(batchExitStr == "1"
  exit()
)
