; export_psf_to_txt.ocn - v5
; Exports sensed I56 output current plus vpre/vpre1 from a plain-Spectre PSF directory.
; v5 expects input.scs to contain:
;   VSENSE_I56 (i56_iout 0) vsource dc=0 type=dc
;   I56 (i56_iout Vdd Vin Vtau Vthr) dynapse1
;   save vpre vpre1 VSENSE_I56:p

caseDir = getShellEnvVar("CAD_CASE_DIR")
unless(caseDir
  error("CAD_CASE_DIR is not set.\n")
)

psfDir  = strcat(caseDir "/psf")
outTmp  = strcat(caseDir "/output_signals.txt.tmp")
outFile = strcat(caseDir "/output_signals.txt")
outList = strcat(caseDir "/available_outputs.txt")

unless(isDir(psfDir)
  error("Cannot find PSF directory: %s\n" psfDir)
)

openResults(psfDir)
selectResult('tran)

; Write available outputs for debugging. Do not fail if this is unsupported.
errset(
  outfile(outList)
  outputs()
  close(outList)
  t
)

; Prefer the inserted sense voltage source. Try several Cadence/Spectre
; naming conventions because PSF current names vary across launcher versions.
iout_56 = nil
foreach(sig list("/VSENSE_I56/PLUS" "/VSENSE_I56/plus" "/VSENSE_I56/P" "/VSENSE_I56/p" "/VSENSE_I56/1")
  when(iout_56 == nil
    tmp = errset(i(sig) t)
    when(tmp
      iout_56 = car(tmp)
      printf("Using sensed current via i(%s)\n" sig)
    )
  )
)

foreach(sig list("VSENSE_I56:p" "VSENSE_I56:PLUS" "VSENSE_I56:1" "/VSENSE_I56/PLUS" "/VSENSE_I56/p")
  when(iout_56 == nil
    tmp = errset(getData(sig) t)
    when(tmp
      iout_56 = car(tmp)
      printf("Using sensed current via getData(%s)\n" sig)
    )
  )
)

; Final fallback: try the subcircuit terminal names from older patches.
foreach(sig list("/I56/Iout" "/I56/iout" "/I56/1")
  when(iout_56 == nil
    tmp = errset(i(sig) t)
    when(tmp
      iout_56 = car(tmp)
      printf("Using subcircuit current via i(%s)\n" sig)
    )
  )
)

unless(iout_56
  error("Could not read I56 output current. See available_outputs.txt in the case directory.\n")
)

vpre  = v("/vpre")
vpre1 = v("/vpre1")

when(isFile(outTmp)
  system(strcat("rm -f \"" outTmp "\""))
)

ocnPrint(?output outTmp ?precision 10 ?numSpaces 1 iout_56 vpre vpre1)
system(strcat("mv -f \"" outTmp "\" \"" outFile "\""))

closeResults(psfDir)
printf("Wrote %s\n" outFile)

batchExitStr = getShellEnvVar("CAD_BATCH_EXIT")
when(batchExitStr == "1"
  exit()
)
