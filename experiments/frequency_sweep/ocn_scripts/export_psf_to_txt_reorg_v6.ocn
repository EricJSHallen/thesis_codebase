; export_psf_to_txt.ocn - v6
; Exports I56 output current proxy plus vpre/vpre1 from a plain-Spectre PSF directory.
; v6 expects input.scs to contain:
;   RSENSE_I56 (i56_iout 0) resistor r=1
;   I56 (i56_iout Vdd Vin Vtau Vthr) dynapse1
;   save vpre vpre1 i56_iout
; Because RSENSE_I56 is 1 ohm, v(i56_iout) is numerically equal to current in amperes.

caseDir = getShellEnvVar("CAD_CASE_DIR")
unless(caseDir
  error("CAD_CASE_DIR is not set.\n")
)

psfDir  = strcat(caseDir "/psf")
outTmp  = strcat(caseDir "/output_signals.txt.tmp")
outFile = strcat(caseDir "/output_signals.txt")

unless(isDir(psfDir)
  error("Cannot find PSF directory: %s\n" psfDir)
)

openResults(psfDir)
selectResult('tran)

; Use only node voltages. This avoids the OCEAN branch-current lookup that hung/froze v5.
iout_56 = nil
foreach(sig list("/i56_iout" "i56_iout")
  when(iout_56 == nil
    tmp = errset(v(sig) t)
    when(tmp
      iout_56 = car(tmp)
      printf("Using I56 output current proxy via v(%s) across 1-ohm RSENSE_I56\n" sig)
    )
  )
)

unless(iout_56
  error("Could not read I56 current proxy voltage i56_iout. Check that input.scs saves i56_iout.\n")
)

vpre  = v("/vpre")
vpre1 = v("/vpre1")

when(isFile(outTmp)
  system(strcat("rm -f \"" outTmp "\""))
)

ocnPrint(?output outTmp ?precision 10 ?numSpaces 1 iout_56 vpre vpre1)
system(strcat("mv -f \"" outTmp "\" \"" outFile "\""))

closeResults(psfDir)
printf("Wrote %s\n" outFile)

batchExitStr = getShellEnvVar("CAD_BATCH_EXIT")
when(batchExitStr == "1"
  exit()
)
