; export_psf_to_txt.ocn - v4
; Exports I56 output current plus vpre/vpre1 from a plain-Spectre PSF directory.

caseDir = getShellEnvVar("CAD_CASE_DIR")
unless(caseDir
  error("CAD_CASE_DIR is not set.\n")
)

psfDir  = strcat(caseDir "/psf")
outTmp  = strcat(caseDir "/output_signals.txt.tmp")
outFile = strcat(caseDir "/output_signals.txt")

unless(isDir(psfDir)
  error("Cannot find PSF directory: %s\n" psfDir)
)

openResults(psfDir)
selectResult('tran)

; The current is expected to be saved by Spectre because input.scs is patched
; to include: saveOptions options ... currents=all
; Try the named subcircuit port first, then a few conservative aliases.
iout_56 = nil
foreach(sig list("/I56/Iout" "/I56/iout" "/I56/1")
  when(iout_56 == nil
    tmp = errset(i(sig) t)
    when(tmp
      iout_56 = car(tmp)
      printf("Using current signal %s\n" sig)
    )
  )
)

unless(iout_56
  error("Could not read I56 output current. Check that input.scs contains currents=all and that the I56 port name is Iout.\n")
)

vpre  = v("/vpre")
vpre1 = v("/vpre1")

when(isFile(outTmp)
  system(strcat("rm -f \"" outTmp "\""))
)

ocnPrint(?output outTmp ?precision 10 ?numSpaces 1 iout_56 vpre vpre1)
system(strcat("mv -f \"" outTmp "\" \"" outFile "\""))

closeResults(psfDir)
printf("Wrote %s\n" outFile)

batchExitStr = getShellEnvVar("CAD_BATCH_EXIT")
when(batchExitStr == "1"
  exit()
)
