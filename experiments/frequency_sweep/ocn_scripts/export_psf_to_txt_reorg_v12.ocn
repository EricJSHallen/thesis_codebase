; export_psf_to_txt.ocn - v12
; Exports I56 output current plus vpre/vpre1 from a plain-Spectre PSF directory.
;
; v12 expects input.scs to contain an ideal 0 V current probe:
;   VSENSE_I56 (i56_iout 0) vsource dc=0 type=dc
;   I56 (i56_iout Vdd Vin Vtau Vthr) dynapse1
;   saveOptions options save=allpub currents=all
;   save vpre vpre1 VSENSE_I56:p VSENSE_I56:n
;
; The v5/v6 failure was caused by invalid OCEAN/SKILL syntax:
;   errset(outfile(...) outputs() close(...) t)
; errset accepts one expression plus an optional print flag. v12 avoids that
; construct entirely and catches only single waveform lookup expressions.

caseDir = getShellEnvVar("CAD_CASE_DIR")
unless(caseDir
  error("CAD_CASE_DIR is not set.\n")
)

psfDir  = strcat(caseDir "/psf")
outTmp  = strcat(caseDir "/output_signals.txt.tmp")
outFile = strcat(caseDir "/output_signals.txt")
diagFile = strcat(caseDir "/current_probe_export_diagnostics.txt")

unless(isDir(psfDir)
  error("Cannot find PSF directory: %s\n" psfDir)
)

openResults(psfDir)
selectResult('tran)

; Open a small diagnostic file. Do not wrap multiple statements inside errset.
diagPort = outfile(diagFile)
fprintf(diagPort "caseDir=%s\n" caseDir)
fprintf(diagPort "psfDir=%s\n" psfDir)

iout_56 = nil
chosenCurrentName = nil

; Helper pattern written inline because older OCEAN/SKILL installations can be
; sensitive to local procedure definitions in batch-loaded files.
foreach(sig list(
    "VSENSE_I56:p"
    "VSENSE_I56:n"
    "VSENSE_I56:PLUS"
    "VSENSE_I56:MINUS"
    "VSENSE_I56:1"
    "VSENSE_I56:2"
    "/VSENSE_I56/p"
    "/VSENSE_I56/n"
    "/VSENSE_I56/PLUS"
    "/VSENSE_I56/MINUS"
    "/VSENSE_I56/1"
    "/VSENSE_I56/2"
  )
  when(iout_56 == nil
    fprintf(diagPort "trying i(%s)\n" sig)
    tmp = errset(i(sig) nil)
    when(tmp
      iout_56 = car(tmp)
      chosenCurrentName = strcat("i(" sig ")")
      fprintf(diagPort "success %s\n" chosenCurrentName)
    )
  )
)

; Some PSF/OCEAN combinations expose branch currents as named data instead of
; through i(). Try getData as a second route.
foreach(sig list(
    "VSENSE_I56:p"
    "VSENSE_I56:n"
    "VSENSE_I56:PLUS"
    "VSENSE_I56:MINUS"
    "VSENSE_I56:1"
    "VSENSE_I56:2"
    "/VSENSE_I56/p"
    "/VSENSE_I56/n"
    "/VSENSE_I56/PLUS"
    "/VSENSE_I56/MINUS"
    "/VSENSE_I56/1"
    "/VSENSE_I56/2"
    "I(VSENSE_I56:p)"
    "I(VSENSE_I56:n)"
    "i(VSENSE_I56:p)"
    "i(VSENSE_I56:n)"
  )
  when(iout_56 == nil
    fprintf(diagPort "trying getData(%s)\n" sig)
    tmp = errset(getData(sig) nil)
    when(tmp
      iout_56 = car(tmp)
      chosenCurrentName = strcat("getData(" sig ")")
      fprintf(diagPort "success %s\n" chosenCurrentName)
    )
  )
)

; Last resort: original subcircuit terminal current names. This should not be
; needed when VSENSE_I56 is saved, but it costs little to try.
foreach(sig list(
    "/I56/Iout"
    "/I56/iout"
    "/I56/1"
    "I56:Iout"
    "I56:iout"
    "I56:1"
  )
  when(iout_56 == nil
    fprintf(diagPort "trying fallback i/getData %s\n" sig)
    tmp = errset(i(sig) nil)
    when(tmp
      iout_56 = car(tmp)
      chosenCurrentName = strcat("i(" sig ")")
      fprintf(diagPort "success %s\n" chosenCurrentName)
    )
    when(iout_56 == nil
      tmp = errset(getData(sig) nil)
      when(tmp
        iout_56 = car(tmp)
        chosenCurrentName = strcat("getData(" sig ")")
        fprintf(diagPort "success %s\n" chosenCurrentName)
      )
    )
  )
)

unless(iout_56
  fprintf(diagPort "FAILED: no current candidate succeeded.\n")
  close(diagPort)
  closeResults(psfDir)
  ; Return normally. The shell wrapper will fail because output_signals.txt is absent.
  batchExitStr = getShellEnvVar("CAD_BATCH_EXIT")
  when(batchExitStr == "1"
    exit()
  )
)

vpre  = v("/vpre")
vpre1 = v("/vpre1")

when(isFile(outTmp)
  system(strcat("rm -f \"" outTmp "\""))
)

fprintf(diagPort "chosenCurrentName=%s\n" chosenCurrentName)
close(diagPort)

; Column order: I56_output_current, vpre, vpre1
ocnPrint(?output outTmp ?precision 10 ?numSpaces 1 iout_56 vpre vpre1)
system(strcat("mv -f \"" outTmp "\" \"" outFile "\""))

closeResults(psfDir)
printf("Wrote %s using %s\n" outFile chosenCurrentName)

batchExitStr = getShellEnvVar("CAD_BATCH_EXIT")
when(batchExitStr == "1"
  exit()
)
