; export_psf_to_txt.ocn
; Export I56 output current plus vpre and vpre1 from one plain-Spectre PSF case.
; Requires the Spectre netlist to contain: save vpre vpre1 I56:Iout

caseDir = getShellEnvVar("CAD_CASE_DIR")
unless(caseDir
  error("CAD_CASE_DIR is not set.\n")
)

psfDir  = strcat(caseDir "/psf")
outTmp  = strcat(caseDir "/output_signals.txt.tmp")
outFile = strcat(caseDir "/output_signals.txt")

unless(isDir(psfDir)
  error("Cannot find PSF directory: %s\n" psfDir)
)

openResults(psfDir)
selectResult('tran)

; Terminal current through the Iout terminal of subcircuit instance I56.
iout_56 = i("/I56/Iout")
unless(iout_56
  error("Could not read i(\"/I56/Iout\"). Confirm the Spectre netlist contains: save I56:Iout, then rerun Spectre.\n")
)

vpre  = v("/vpre")
vpre1 = v("/vpre1")
unless(vpre
  error("Could not read v(\"/vpre\").\n")
)
unless(vpre1
  error("Could not read v(\"/vpre1\").\n")
)

when(isFile(outTmp)
  system(strcat("rm -f \"" outTmp "\""))
)

ocnPrint(?output outTmp ?precision 10 ?numSpaces 1 iout_56 vpre vpre1)

unless(isFile(outTmp)
  error("ocnPrint did not create %s\n" outTmp)
)

system(strcat("mv -f \"" outTmp "\" \"" outFile "\""))
closeResults(psfDir)
printf("Wrote %s with i(/I56/Iout), v(/vpre), v(/vpre1)\n" outFile)

batchExitStr = getShellEnvVar("CAD_BATCH_EXIT")
when(batchExitStr == "1"
  exit()
)
